* TB8: Simplified Dual Resistive-Load Switching Simulation with Generic Level 1 NMOS Models
* Channel 1: 4.0A load (6.0R) @ 1kHz, Channel 2: 2.5A load (9.6R) @ 2kHz.
* NOTE: Simplified model; does not evaluate board crosstalk, cable parasitics, thermal coupling, or shoot-through.
V24 v24_rail 0 DC 24
Vch1_in ch1_gate 0 PULSE(0 5 0 20n 20n 0.5m 1.0m)
M1 drain1 ch1_gate 0 0 MNOM
Rload1 v24_rail drain1 6.0
Vch2_in ch2_gate 0 PULSE(0 5 0.25m 20n 20n 0.25m 0.5m)
M2 drain2 ch2_gate 0 0 MNOM
Rload2 v24_rail drain2 9.6
.model MNOM NMOS(Vto=1.7 Kp=40 Rs=0.01 Rd=0.01)
.tran 5u 3m 1m
.control
run
wrdata tb8_out.txt v(drain1) v(drain2)
quit
.endc
.end
