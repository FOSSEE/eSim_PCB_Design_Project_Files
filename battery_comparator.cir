* C:\Users\ADMIN\eSim-Workspace\battery_comparator\battery_comparator.cir

* EESchema Netlist Version 1.1 (Spice format) creation date: 08/23/26 18:03:04

* To exclude a component from the Spice Netlist add [Spice_Netlist_Enabled] user FIELD set to: N
* To reorder the component spice node sequence add [Spice_Node_Sequence] user FIELD and define sequence: 2,1,0

* Sheet Name: /
X1  ? Net-_R4-Pad2_ Net-_R2-Pad2_ GND ? Net-_R7-Pad2_ Net-_C1-Pad1_ ? lm_741
R5  Net-_R4-Pad2_ GND 10k
R4  Net-_R4-Pad1_ Net-_R4-Pad2_ 10k
R6  Net-_R6-Pad1_ Net-_D2-Pad2_ 330
C1  Net-_C1-Pad1_ GND 100n
D2  GND Net-_D2-Pad2_ eSim_LED
D1  GND Net-_D1-Pad2_ eSim_LED
X2  ? Net-_R1-Pad2_ Net-_R4-Pad2_ GND ? Net-_R6-Pad1_ Net-_R4-Pad1_ ? lm_741
R1  Net-_C1-Pad1_ Net-_R1-Pad2_ 4.7k
R2  Net-_R1-Pad2_ Net-_R2-Pad2_ 3.3k
R3  Net-_R2-Pad2_ GND 2.2k
R7  Net-_D1-Pad2_ Net-_R7-Pad2_ 330
v1  Net-_C1-Pad1_ GND 12
v2  Net-_R4-Pad1_ GND 12

.end
