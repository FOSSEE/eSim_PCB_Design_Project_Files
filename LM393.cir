* C:\FOSSEE\eSim\library\SubcircuitLibrary\LM393\LM393.cir

* EESchema Netlist Version 1.1 (Spice format) creation date: 08/29/22 20:35:27

* To exclude a component from the Spice Netlist add [Spice_Netlist_Enabled] user FIELD set to: N
* To reorder the component spice node sequence add [Spice_Node_Sequence] user FIELD and define sequence: 2,1,0

* Sheet Name: /
Q1  Net-_Q1-Pad1_ Net-_Q1-Pad2_ Net-_J1-Pad1_ eSim_PNP
R2  Net-_Q1-Pad2_ Net-_Q1-Pad1_ 2k
Q4  Net-_J1-Pad3_ Net-_Q1-Pad1_ Net-_J1-Pad1_ eSim_PNP
Q5  Net-_Q2-Pad3_ Net-_Q1-Pad1_ Net-_J1-Pad1_ eSim_PNP
Q8  Net-_D4-Pad1_ Net-_Q1-Pad1_ Net-_Q7-Pad3_ eSim_PNP
Q10  Net-_Q10-Pad1_ Net-_Q1-Pad1_ Net-_J1-Pad1_ eSim_PNP
Q14  Net-_Q14-Pad1_ Net-_Q1-Pad1_ Net-_J1-Pad1_ eSim_PNP
Q2  Net-_Q1-Pad1_ Net-_J1-Pad3_ Net-_Q2-Pad3_ eSim_NPN
R1  Net-_Q2-Pad3_ Net-_D3-Pad2_ 4.6k
J1  Net-_J1-Pad1_ Net-_D3-Pad2_ Net-_J1-Pad3_ jfet_n
Q3  Net-_J1-Pad3_ Net-_Q2-Pad3_ Net-_D3-Pad2_ eSim_NPN
D2  Net-_D2-Pad1_ Net-_D1-Pad2_ eSim_Diode
D1  Net-_D1-Pad1_ Net-_D1-Pad2_ eSim_Diode
Q6  Net-_D3-Pad2_ Net-_D1-Pad1_ Net-_D1-Pad2_ eSim_PNP
Q9  Net-_D3-Pad1_ Net-_D1-Pad2_ Net-_Q10-Pad1_ eSim_PNP
Q12  Net-_Q11-Pad1_ Net-_D4-Pad2_ Net-_Q10-Pad1_ eSim_PNP
D3  Net-_D3-Pad1_ Net-_D3-Pad2_ eSim_Diode
Q11  Net-_Q11-Pad1_ Net-_D3-Pad1_ Net-_D3-Pad2_ eSim_NPN
D4  Net-_D4-Pad1_ Net-_D4-Pad2_ eSim_Diode
Q13  Net-_D3-Pad2_ Net-_D5-Pad1_ Net-_D4-Pad2_ eSim_PNP
D5  Net-_D5-Pad1_ Net-_D4-Pad2_ eSim_Diode
Q15  Net-_Q14-Pad1_ Net-_Q11-Pad1_ Net-_D3-Pad2_ eSim_NPN
Q16  Net-_Q16-Pad1_ Net-_Q14-Pad1_ Net-_D3-Pad2_ eSim_NPN
R3  Net-_J1-Pad1_ Net-_Q7-Pad3_ 2.1k
U1  Net-_J1-Pad1_ Net-_D1-Pad1_ Net-_D5-Pad1_ Net-_Q16-Pad1_ Net-_D3-Pad2_ Net-_D6-Pad1_ Net-_D10-Pad1_ Net-_Q32-Pad1_ PORT
Q7  Net-_D2-Pad1_ Net-_Q1-Pad1_ Net-_Q7-Pad3_ eSim_PNP
Q17  Net-_Q17-Pad1_ Net-_Q17-Pad2_ Net-_J1-Pad1_ eSim_PNP
R5  Net-_Q17-Pad2_ Net-_Q17-Pad1_ 2k
Q20  Net-_J2-Pad3_ Net-_Q17-Pad1_ Net-_J1-Pad1_ eSim_PNP
Q21  Net-_Q18-Pad3_ Net-_Q17-Pad1_ Net-_J1-Pad1_ eSim_PNP
Q24  Net-_D9-Pad1_ Net-_Q17-Pad1_ Net-_Q23-Pad3_ eSim_PNP
Q26  Net-_Q25-Pad3_ Net-_Q17-Pad1_ Net-_J1-Pad1_ eSim_PNP
Q30  Net-_Q30-Pad1_ Net-_Q17-Pad1_ Net-_J1-Pad1_ eSim_PNP
Q18  Net-_Q17-Pad1_ Net-_J2-Pad3_ Net-_Q18-Pad3_ eSim_NPN
R4  Net-_Q18-Pad3_ Net-_D3-Pad2_ 4.6k
J2  Net-_J1-Pad1_ Net-_D3-Pad2_ Net-_J2-Pad3_ jfet_n
Q19  Net-_J2-Pad3_ Net-_Q18-Pad3_ Net-_D3-Pad2_ eSim_NPN
D7  Net-_D7-Pad1_ Net-_D6-Pad2_ eSim_Diode
D6  Net-_D6-Pad1_ Net-_D6-Pad2_ eSim_Diode
Q22  Net-_D3-Pad2_ Net-_D6-Pad1_ Net-_D6-Pad2_ eSim_PNP
Q25  Net-_D8-Pad1_ Net-_D6-Pad2_ Net-_Q25-Pad3_ eSim_PNP
Q28  Net-_Q27-Pad1_ Net-_D10-Pad2_ Net-_Q25-Pad3_ eSim_PNP
D8  Net-_D8-Pad1_ Net-_D3-Pad2_ eSim_Diode
Q27  Net-_Q27-Pad1_ Net-_D8-Pad1_ Net-_D3-Pad2_ eSim_NPN
D9  Net-_D9-Pad1_ Net-_D10-Pad2_ eSim_Diode
Q29  Net-_D3-Pad2_ Net-_D10-Pad1_ Net-_D10-Pad2_ eSim_PNP
D10  Net-_D10-Pad1_ Net-_D10-Pad2_ eSim_Diode
Q31  Net-_Q30-Pad1_ Net-_Q27-Pad1_ Net-_D3-Pad2_ eSim_NPN
Q32  Net-_Q32-Pad1_ Net-_Q30-Pad1_ Net-_D3-Pad2_ eSim_NPN
R6  Net-_J1-Pad1_ Net-_Q23-Pad3_ 2.1k
Q23  Net-_D7-Pad1_ Net-_Q17-Pad1_ Net-_Q23-Pad3_ eSim_PNP

.end
